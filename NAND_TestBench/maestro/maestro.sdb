ADE simulation setup
Run mode: Single Run, Sweeps and Corners
Tests:
  progress_xp_NAND_TestBench_1: progress_xp/NAND_TestBench/schematic, simulator spectre
