ADE simulation setup
Test progress_xp_NOT_TestBench_1: progress_xp/NOT_TestBench/schematic, simulator spectre
  Models: /opt/cadence-suite/sky130_release_0.0.4/libs/sky130_fd_pr_main/../../models/sky130.lib.spice[tt]
  Temperature: 27
  Analysis tran: stop=200n errpreset=moderate
  Signals: /A, /Vout
Run mode: Single Run, Sweeps and Corners
