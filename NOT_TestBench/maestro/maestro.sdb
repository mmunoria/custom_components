ADE simulation setup
Run mode: Single Run, Sweeps and Corners
Tests:
  progress_xp_NOT_TestBench_1: progress_xp/NOT_TestBench/schematic, simulator spectre
